`include "discipline.h"
`include "constants.h"
// dac4
//
// -  4 bit digital analog converter
//
// vd0..vd3:	data inputs [V,A]
// vout:	[V,A]
//
// INSTANCE parameters
//    vref   = reference voltage that conversion is with respect to [V]
//    vtrans = transition voltage between logic high and low [V]
//    tdel,trise,tfall = {usual} [s]
//
// MODEL parameters
//    {none}

module dac4 (vd3,vd2,vd1,vd0,vout);
input vd3, vd2, vd1, vd0;
output vout;
electrical vd3, vd2, vd1, vd0, vout;
parameter real vref  = 1 from [0:inf);
parameter real trise = 1n from [0:inf);
parameter real tfall = 1n from [0:inf);
parameter real tdel  = 1n from [0:inf);
parameter real vtrans  = 0.65;

    real out_scaled; // output scaled as fraction of 16

    analog begin
		out_scaled = 0;
		out_scaled = out_scaled + ((V(vd3) > vtrans) ? 8 : 0);
		out_scaled = out_scaled + ((V(vd2) > vtrans) ? 4 : 0);
		out_scaled = out_scaled + ((V(vd1) > vtrans) ? 2 : 0);
		out_scaled = out_scaled + ((V(vd0) > vtrans) ? 1 : 0);
		V(vout) <+ transition( vref*out_scaled/16, tdel, trise, tfall );
    end
endmodule
